* auto-built from _ph_real.net (real schematic wiring)
.include "/home/akiel/trunk/pub/signalmesh_CAD/sim/spice/models/behavioral.lib"
.options rshunt=1e12 gmin=1e-9 reltol=1e-3
V5 P5V 0 5
VN5 N5V 0 -5
V__CV_FX2 _CV_FX2 0 -4.6
V__PH_R_IN _PH_R_IN 0 0.0
Vin _PH_L_IN 0 dc 0 ac 1
C904 _OO_L1 0 1n
C910 _OO_L2 0 1n
C916 _OO_L3 0 1n
C922 _OO_L4 0 1n
C930 _OO_R1 0 1n
C936 _OO_R2 0 1n
C942 _OO_R3 0 1n
C948 _OO_R4 0 1n
C980 P5V 0 100n
C981 N5V 0 100n
C982 P5V 0 100n
C983 N5V 0 100n
C984 P5V 0 100n
C985 N5V 0 100n
C986 P5V 0 100n
C987 N5V 0 100n
C988 P5V 0 100n
C989 N5V 0 100n
C990 P5V 0 100n
R901 _S1_L _ATT_L1 22e3
R902 _ATT_L1 0 220
R903 _CV_FX2 _IAB_L1 100e3
R905 _S1_L _DN_L1 10e3
R906 _AP1_L _DN_L1 10e3
R907 _AP1_L _ATT_L2 22e3
R908 _ATT_L2 0 220
R909 _CV_FX2 _IAB_L2 100e3
R911 _AP1_L _DN_L2 10e3
R912 _AP2_L _DN_L2 10e3
R913 _AP2_L _ATT_L3 22e3
R914 _ATT_L3 0 220
R915 _CV_FX2 _IAB_L3 100e3
R917 _AP2_L _DN_L3 10e3
R918 _AP3_L _DN_L3 10e3
R919 _AP3_L _ATT_L4 22e3
R920 _ATT_L4 0 220
R921 _CV_FX2 _IAB_L4 100e3
R923 _AP3_L _DN_L4 10e3
R924 _AP4_L _DN_L4 10e3
R925 _PH_L_IN _S1_L 100e3
R926 _AP4_L _S1_L 47e3
R927 _S1_R _ATT_R1 22e3
R928 _ATT_R1 0 220
R929 _CV_FX2 _IAB_R1 100e3
R931 _S1_R _DN_R1 10e3
R932 _AP1_R _DN_R1 10e3
R933 _AP1_R _ATT_R2 22e3
R934 _ATT_R2 0 220
R935 _CV_FX2 _IAB_R2 100e3
R937 _AP1_R _DN_R2 10e3
R938 _AP2_R _DN_R2 10e3
R939 _AP2_R _ATT_R3 22e3
R940 _ATT_R3 0 220
R941 _CV_FX2 _IAB_R3 100e3
R943 _AP2_R _DN_R3 10e3
R944 _AP3_R _DN_R3 10e3
R945 _AP3_R _ATT_R4 22e3
R946 _ATT_R4 0 220
R947 _CV_FX2 _IAB_R4 100e3
R949 _AP3_R _DN_R4 10e3
R950 _AP4_R _DN_R4 10e3
R951 _PH_R_IN _S1_R 100e3
R952 _AP4_R _S1_R 47e3
R953 _PH_L_IN _MN_L 22e3
R954 _AP4_L _MN_L 22e3
R955 _WET_L _MN_L 22e3
R956 _PH_R_IN _MN_R 22e3
R957 _AP4_R _MN_R 22e3
R958 _WET_R _MN_R 22e3
XU50A _IAB_L1 _ATT_L1 _VLP_L1 _OO_L1 _OO_L1 _VLP_L1 P5V N5V LM13700_HALF
XU50B _IAB_L2 _ATT_L2 _VLP_L2 _OO_L2 _OO_L2 _VLP_L2 P5V N5V LM13700_HALF
XU51A _IAB_L3 _ATT_L3 _VLP_L3 _OO_L3 _OO_L3 _VLP_L3 P5V N5V LM13700_HALF
XU51B _IAB_L4 _ATT_L4 _VLP_L4 _OO_L4 _OO_L4 _VLP_L4 P5V N5V LM13700_HALF
XU54 _AP1_L _DN_L1 _VLP_L1 _AP2_L _DN_L2 _VLP_L2 P5V N5V OPA1678
XU55 _AP3_L _DN_L3 _VLP_L3 _AP4_L _DN_L4 _VLP_L4 P5V N5V OPA1678
XU57A _IAB_R1 _ATT_R1 _VLP_R1 _OO_R1 _OO_R1 _VLP_R1 P5V N5V LM13700_HALF
XU57B _IAB_R2 _ATT_R2 _VLP_R2 _OO_R2 _OO_R2 _VLP_R2 P5V N5V LM13700_HALF
XU58A _IAB_R3 _ATT_R3 _VLP_R3 _OO_R3 _OO_R3 _VLP_R3 P5V N5V LM13700_HALF
XU58B _IAB_R4 _ATT_R4 _VLP_R4 _OO_R4 _OO_R4 _VLP_R4 P5V N5V LM13700_HALF
XU60 _AP1_R _DN_R1 _VLP_R1 _AP2_R _DN_R2 _VLP_R2 P5V N5V OPA1678
XU61 _AP3_R _DN_R3 _VLP_R3 _AP4_R _DN_R4 _VLP_R4 P5V N5V OPA1678
XU62 _WET_L _MN_L 0 _WET_R _MN_R 0 P5V N5V OPA1678
Rmux_U63_14 _PH_L_OUT _WET_L 1
.control
ac dec 30 20 20k
wrdata /home/akiel/trunk/pub/signalmesh_CAD/sim/spice/_ph_real.txt db(v(_PH_L_OUT))
.endc
.end

* auto-built from _chain.net (real schematic wiring)
.include "/home/akiel/trunk/pub/signalmesh_CAD/sim/spice/models/behavioral.lib"
.options rshunt=1e12 gmin=1e-9 reltol=1e-3
V5 P5V 0 5
VN5 N5V 0 -5
V__ANALOG_FILTER_CV_CV_CUTOFF _ANALOG_FILTER_CV_CV_CUTOFF 0 -3.0
V__ANALOG_FILTER_CV_CV_RES _ANALOG_FILTER_CV_CV_RES 0 -4.9
V__ANALOG_FILTER_CV_CV_VCA _ANALOG_FILTER_CV_CV_VCA 0 0.0
V__ANALOG_FILTER_CV_CV_MOD _ANALOG_FILTER_CV_CV_MOD 0 0.0
V__MF_CV_CUTOFF _MF_CV_CUTOFF 0 -4.7
V__MF_CV_RES _MF_CV_RES 0 -4.99
V__CV_FX1 _CV_FX1 0 -4.9
V__CV_FX2 _CV_FX2 0 -3.0
V__CV_FX3 _CV_FX3 0 -3.0
Vin _CH_L_IN 0 dc 0 ac 1
C6 Net__U2A___ Net__U3A___ 1u
C7 0 Net__U2A___ 560p
C8 Net__C8_Pad1_ Net__U2A___ 1n
C11 0 Net__U2B___ 560p
C12 Net__C12_Pad1_ Net__U2B___ 1n
C13 Net__U2B___ Net__U3B___ 1u
R1 Net__U3A___ 0 100000.0
R2 Net__J2_In_ Net__C8_Pad1_ 10000.0
R3 Net__C8_Pad1_ Net__U2A___ 10000.0
R4 Net__U3A___ _FILT_L_IN 100.0
R5 Net__J3_In_ Net__C12_Pad1_ 10000.0
R6 Net__C12_Pad1_ Net__U2B___ 10000.0
R7 Net__U3B___ 0 100000.0
R8 Net__U3B___ _FILT_R_IN 100.0
XU2 Net__U2A___ Net__U2A___ Net__U2A___ Net__U2B___ Net__U2B___ Net__U2B___ P5V N5V OPA1678
XU3 Net__U3A___ Net__U3A___ Net__U3A___ Net__U3B___ Net__U3B___ Net__U3B___ P5V N5V OPA1678
C904 _FX_PHASER_OO_L1 0 1n
C910 _FX_PHASER_OO_L2 0 1n
C916 _FX_PHASER_OO_L3 0 1n
C922 _FX_PHASER_OO_L4 0 1n
C930 _FX_PHASER_OO_R1 0 1n
C936 _FX_PHASER_OO_R2 0 1n
C942 _FX_PHASER_OO_R3 0 1n
C948 _FX_PHASER_OO_R4 0 1n
C980 P5V 0 100n
C981 N5V 0 100n
C982 P5V 0 100n
C983 N5V 0 100n
C984 P5V 0 100n
C985 N5V 0 100n
C986 P5V 0 100n
C987 N5V 0 100n
C988 P5V 0 100n
C989 N5V 0 100n
C990 P5V 0 100n
R901 _FX_PHASER_S1_L _FX_PHASER_ATT_L1 22000.0
R902 _FX_PHASER_ATT_L1 0 220.0
R903 _CV_FX2 _FX_PHASER_IAB_L1 100000.0
R905 _FX_PHASER_S1_L _FX_PHASER_DN_L1 10000.0
R906 _FX_PHASER_AP1_L _FX_PHASER_DN_L1 10000.0
R907 _FX_PHASER_AP1_L _FX_PHASER_ATT_L2 22000.0
R908 _FX_PHASER_ATT_L2 0 220.0
R909 _CV_FX2 _FX_PHASER_IAB_L2 100000.0
R911 _FX_PHASER_AP1_L _FX_PHASER_DN_L2 10000.0
R912 _FX_PHASER_AP2_L _FX_PHASER_DN_L2 10000.0
R913 _FX_PHASER_AP2_L _FX_PHASER_ATT_L3 22000.0
R914 _FX_PHASER_ATT_L3 0 220.0
R915 _CV_FX2 _FX_PHASER_IAB_L3 100000.0
R917 _FX_PHASER_AP2_L _FX_PHASER_DN_L3 10000.0
R918 _FX_PHASER_AP3_L _FX_PHASER_DN_L3 10000.0
R919 _FX_PHASER_AP3_L _FX_PHASER_ATT_L4 22000.0
R920 _FX_PHASER_ATT_L4 0 220.0
R921 _CV_FX2 _FX_PHASER_IAB_L4 100000.0
R923 _FX_PHASER_AP3_L _FX_PHASER_DN_L4 10000.0
R924 _FX_PHASER_AP4_L _FX_PHASER_DN_L4 10000.0
R925 _FX_L_OUT _FX_PHASER_S1_L 100000.0
R926 _FX_PHASER_AP4_L _FX_PHASER_S1_L 47000.0
R927 _FX_PHASER_S1_R _FX_PHASER_ATT_R1 22000.0
R928 _FX_PHASER_ATT_R1 0 220.0
R929 _CV_FX2 _FX_PHASER_IAB_R1 100000.0
R931 _FX_PHASER_S1_R _FX_PHASER_DN_R1 10000.0
R932 _FX_PHASER_AP1_R _FX_PHASER_DN_R1 10000.0
R933 _FX_PHASER_AP1_R _FX_PHASER_ATT_R2 22000.0
R934 _FX_PHASER_ATT_R2 0 220.0
R935 _CV_FX2 _FX_PHASER_IAB_R2 100000.0
R937 _FX_PHASER_AP1_R _FX_PHASER_DN_R2 10000.0
R938 _FX_PHASER_AP2_R _FX_PHASER_DN_R2 10000.0
R939 _FX_PHASER_AP2_R _FX_PHASER_ATT_R3 22000.0
R940 _FX_PHASER_ATT_R3 0 220.0
R941 _CV_FX2 _FX_PHASER_IAB_R3 100000.0
R943 _FX_PHASER_AP2_R _FX_PHASER_DN_R3 10000.0
R944 _FX_PHASER_AP3_R _FX_PHASER_DN_R3 10000.0
R945 _FX_PHASER_AP3_R _FX_PHASER_ATT_R4 22000.0
R946 _FX_PHASER_ATT_R4 0 220.0
R947 _CV_FX2 _FX_PHASER_IAB_R4 100000.0
R949 _FX_PHASER_AP3_R _FX_PHASER_DN_R4 10000.0
R950 _FX_PHASER_AP4_R _FX_PHASER_DN_R4 10000.0
R951 _FX_R_OUT _FX_PHASER_S1_R 100000.0
R952 _FX_PHASER_AP4_R _FX_PHASER_S1_R 47000.0
R953 _FX_L_OUT _FX_PHASER_MN_L 22000.0
R954 _FX_PHASER_AP4_L _FX_PHASER_MN_L 22000.0
R955 _FX_PHASER_WET_L _FX_PHASER_MN_L 22000.0
R956 _FX_R_OUT _FX_PHASER_MN_R 22000.0
R957 _FX_PHASER_AP4_R _FX_PHASER_MN_R 22000.0
R958 _FX_PHASER_WET_R _FX_PHASER_MN_R 22000.0
XU50A _FX_PHASER_IAB_L1 _FX_PHASER_ATT_L1 _FX_PHASER_VLP_L1 _FX_PHASER_OO_L1 _FX_PHASER_OO_L1 _FX_PHASER_VLP_L1 P5V N5V LM13700_HALF
XU50B _FX_PHASER_IAB_L2 _FX_PHASER_ATT_L2 _FX_PHASER_VLP_L2 _FX_PHASER_OO_L2 _FX_PHASER_OO_L2 _FX_PHASER_VLP_L2 P5V N5V LM13700_HALF
XU51A _FX_PHASER_IAB_L3 _FX_PHASER_ATT_L3 _FX_PHASER_VLP_L3 _FX_PHASER_OO_L3 _FX_PHASER_OO_L3 _FX_PHASER_VLP_L3 P5V N5V LM13700_HALF
XU51B _FX_PHASER_IAB_L4 _FX_PHASER_ATT_L4 _FX_PHASER_VLP_L4 _FX_PHASER_OO_L4 _FX_PHASER_OO_L4 _FX_PHASER_VLP_L4 P5V N5V LM13700_HALF
XU54 _FX_PHASER_AP1_L _FX_PHASER_DN_L1 _FX_PHASER_VLP_L1 _FX_PHASER_AP2_L _FX_PHASER_DN_L2 _FX_PHASER_VLP_L2 P5V N5V OPA1678
XU55 _FX_PHASER_AP3_L _FX_PHASER_DN_L3 _FX_PHASER_VLP_L3 _FX_PHASER_AP4_L _FX_PHASER_DN_L4 _FX_PHASER_VLP_L4 P5V N5V OPA1678
XU57A _FX_PHASER_IAB_R1 _FX_PHASER_ATT_R1 _FX_PHASER_VLP_R1 _FX_PHASER_OO_R1 _FX_PHASER_OO_R1 _FX_PHASER_VLP_R1 P5V N5V LM13700_HALF
XU57B _FX_PHASER_IAB_R2 _FX_PHASER_ATT_R2 _FX_PHASER_VLP_R2 _FX_PHASER_OO_R2 _FX_PHASER_OO_R2 _FX_PHASER_VLP_R2 P5V N5V LM13700_HALF
XU58A _FX_PHASER_IAB_R3 _FX_PHASER_ATT_R3 _FX_PHASER_VLP_R3 _FX_PHASER_OO_R3 _FX_PHASER_OO_R3 _FX_PHASER_VLP_R3 P5V N5V LM13700_HALF
XU58B _FX_PHASER_IAB_R4 _FX_PHASER_ATT_R4 _FX_PHASER_VLP_R4 _FX_PHASER_OO_R4 _FX_PHASER_OO_R4 _FX_PHASER_VLP_R4 P5V N5V LM13700_HALF
XU60 _FX_PHASER_AP1_R _FX_PHASER_DN_R1 _FX_PHASER_VLP_R1 _FX_PHASER_AP2_R _FX_PHASER_DN_R2 _FX_PHASER_VLP_R2 P5V N5V OPA1678
XU61 _FX_PHASER_AP3_R _FX_PHASER_DN_R3 _FX_PHASER_VLP_R3 _FX_PHASER_AP4_R _FX_PHASER_DN_R4 _FX_PHASER_VLP_R4 P5V N5V OPA1678
XU62 _FX_PHASER_WET_L _FX_PHASER_MN_L 0 _FX_PHASER_WET_R _FX_PHASER_MN_R 0 P5V N5V OPA1678
C50 _FX_CONTROL_VREF2 0 1u
C51 P5V 0 100n
C52 P5V 0 100n
C53 P5V 0 10u
C55 _3V3 0 100n
C56 P5V 0 1u
C57 _3V3 0 1u
C25 _ANALOG_FILTER_CV_VREF 0 1u
C30 _ANALOG_FILTER_CV_VCF_L_OUT 0 1n
C40 _ANALOG_FILTER_CV_VCF_R_OUT 0 1n
C90 P5V 0 100n
C91 N5V 0 100n
C92 P5V 0 100n
C93 N5V 0 100n
C94 P5V 0 100n
C95 N5V 0 100n
R20 _ANALOG_FILTER_CV_CV_CUTOFF Net__U5A___ 100000.0
R21 _ANALOG_FILTER_CV_CV_MOD Net__U5A___ 100000.0
R23 Net__U5A___ _ANALOG_FILTER_CV_VCUTOFF 100000.0
R30 _FILT_L_IN Net__U4C___ 20000.0
R31 Net__R31_Pad1_ _ANALOG_FILTER_CV_VCUTOFF 100000.0
R32 _ANALOG_FILTER_CV_VCF_L_OUT 0 47000.0
R35 _ANALOG_FILTER_CV_VCF_L_OUT Net__U4A___ 20000.0
R36 Net__R36_Pad1_ _ANALOG_FILTER_CV_CV_VCA 100000.0
R37 _ANALOG_FILTER_CV_VCA_L_OUT 0 47000.0
R40 _FILT_R_IN Net__U8C___ 20000.0
R41 Net__R41_Pad1_ _ANALOG_FILTER_CV_VCUTOFF 100000.0
R42 _ANALOG_FILTER_CV_VCF_R_OUT 0 47000.0
R45 _ANALOG_FILTER_CV_VCF_R_OUT Net__U8A___ 20000.0
R46 Net__R46_Pad1_ _ANALOG_FILTER_CV_CV_VCA 100000.0
R47 _ANALOG_FILTER_CV_VCA_R_OUT 0 47000.0
XU4A Net__R31_Pad1_ Net__U4C___ 0 _ANALOG_FILTER_CV_VCF_L_OUT nc_U4_7 nc_U4_8 P5V N5V LM13700_HALF
XU4B Net__R36_Pad1_ Net__U4A___ 0 _ANALOG_FILTER_CV_VCA_L_OUT nc_U4_10 nc_U4_9 P5V N5V LM13700_HALF
XU5 _ANALOG_FILTER_CV_VCUTOFF Net__U5A___ 0 nc_U5_7 nc_U5_6 nc_U5_5 P5V N5V OPA1678
XU8A Net__R41_Pad1_ Net__U8C___ 0 _ANALOG_FILTER_CV_VCF_R_OUT nc_U8_7 nc_U8_8 P5V N5V LM13700_HALF
XU8B Net__R46_Pad1_ Net__U8A___ 0 _ANALOG_FILTER_CV_VCA_R_OUT nc_U8_10 nc_U8_9 P5V N5V LM13700_HALF
C1053 _FX_CHORUS_VMID 0 10u
C1055 _FX_CHORUS_OSC3 0 100p
C1056 _FX_CHORUS_OSC2 _FX_CHORUS_OSC3 100p
C1060 _FX_CHORUS_AA_L _FX_CHORUS_IL_L 1n
C1064 _FX_CHORUS_WET_L _FX_CHORUS_OL_L 1n
C1070 _FX_CHORUS_AA_R _FX_CHORUS_IL_R 1n
C1074 _FX_CHORUS_WET_R _FX_CHORUS_OL_R 1n
C1085 P5V 0 100n
C1086 N5V 0 100n
C1087 P5V 0 100n
C1088 N5V 0 100n
C1089 P5V 0 100n
C1090 N5V 0 100n
C1091 P5V 0 100n
C1092 N5V 0 100n
R1051 P5V _FX_CHORUS_VMIDR 100000.0
R1052 _FX_CHORUS_VMIDR 0 100000.0
R1054 _FX_CHORUS_OSC1 _FX_CHORUS_OSC2 47000.0
R1057 _CV_FX3 _FX_CHORUS_OSC1 220000.0
R1058 _CH_L_IN _FX_CHORUS_IL_L 10000.0
R1059 _FX_CHORUS_AA_L _FX_CHORUS_IL_L 10000.0
R1061 _FX_CHORUS_BO1_L _FX_CHORUS_OL_L 10000.0
R1062 _FX_CHORUS_BO2_L _FX_CHORUS_OL_L 10000.0
R1063 _FX_CHORUS_WET_L _FX_CHORUS_OL_L 10000.0
R1065 _CH_L_IN _FX_CHORUS_ML_L 22000.0
R1066 _FX_CHORUS_WET_L _FX_CHORUS_ML_L 22000.0
R1067 _FX_CHORUS_CHW_L _FX_CHORUS_ML_L 22000.0
R1068 _CH_R_IN _FX_CHORUS_IL_R 10000.0
R1069 _FX_CHORUS_AA_R _FX_CHORUS_IL_R 10000.0
R1071 _FX_CHORUS_BO1_R _FX_CHORUS_OL_R 10000.0
R1072 _FX_CHORUS_BO2_R _FX_CHORUS_OL_R 10000.0
R1073 _FX_CHORUS_WET_R _FX_CHORUS_OL_R 10000.0
R1075 _CH_R_IN _FX_CHORUS_ML_R 22000.0
R1076 _FX_CHORUS_WET_R _FX_CHORUS_ML_R 22000.0
R1077 _FX_CHORUS_CHW_R _FX_CHORUS_ML_R 22000.0
XU73 _FX_CHORUS_AA_L _FX_CHORUS_IL_L _FX_CHORUS_VMID _FX_CHORUS_AA_R _FX_CHORUS_IL_R _FX_CHORUS_VMID P5V N5V OPA1678
XU74 _FX_CHORUS_WET_L _FX_CHORUS_OL_L _FX_CHORUS_VMID _FX_CHORUS_WET_R _FX_CHORUS_OL_R _FX_CHORUS_VMID P5V N5V OPA1678
XU75 _FX_CHORUS_CHW_L _FX_CHORUS_ML_L 0 _FX_CHORUS_CHW_R _FX_CHORUS_ML_R 0 P5V N5V OPA1678
Rmux_U76_14 _VOL_L _CH_L_IN 1
Rmux_U76_15 _VOL_R _CH_R_IN 1
XU77 _FX_CHORUS_VMID _FX_CHORUS_VMID _FX_CHORUS_VMIDR nc_U77_7 nc_U77_6 nc_U77_5 P5V N5V OPA1678
C1 P5V 0 10u
C2 Net__U1_CAP__ Net__U1_CAP__ 10u
C3 N5V 0 10u
C18 P5V 0 100n
C19 N5V 0 100n
C20 P5V 0 100n
C21 N5V 0 100n
C60 Net__U15_CAP__ Net__U15_CAP__ 1u
C61 N5V 0 22u
R11 P5V Net__D1_A_ 1000.0
R12 0 Net__D2_A_ 1000.0
R13 _3V3 Net__D3_A_ 1000.0
C110 Net__C110_Pad1_ 0 1n
C114 Net__C114_Pad1_ 0 1n
C210 Net__C210_Pad1_ 0 1n
C214 Net__C214_Pad1_ 0 1n
C500 P5V 0 100n
C501 N5V 0 100n
C502 P5V 0 100n
C503 N5V 0 100n
C504 P5V 0 100n
C505 N5V 0 100n
C506 P5V 0 100n
C507 N5V 0 100n
C508 P5V 0 100n
C509 N5V 0 100n
C510 P5V 0 100n
C511 N5V 0 100n
C512 P5V 0 100n
C513 N5V 0 100n
C514 P5V 0 100n
C515 N5V 0 100n
R100 _FILT_L_OUT Net__U30A___ 100000.0
R101 _MASTER_FILTER_LPL Net__U30A___ 100000.0
R102 _MASTER_FILTER_RESFBL Net__U30A___ 100000.0
R103 Net__U30A___ _MASTER_FILTER_HPL 100000.0
R104 _MASTER_FILTER_HPL Net__U30B___ 100000.0
R105 _MASTER_FILTER_LPL Net__U30B___ 100000.0
R106 Net__U30B___ _MASTER_FILTER_NOTCHL 100000.0
R110 _MASTER_FILTER_HPL Net__U31C___ 22000.0
R111 _MASTER_FILTER_HPL 0 220.0
R112 Net__R112_Pad1_ _MF_CV_CUTOFF 100000.0
R113 _MASTER_FILTER_BPL N5V 10000.0
R114 _MASTER_FILTER_BPL Net__U31A___ 22000.0
R115 _MASTER_FILTER_BPL 0 220.0
R116 Net__R116_Pad1_ _MF_CV_CUTOFF 100000.0
R117 _MASTER_FILTER_LPL N5V 10000.0
R118 _MASTER_FILTER_BPL Net__U32C___ 22000.0
R119 _MASTER_FILTER_BPL 0 220.0
R120 Net__R120_Pad1_ _MF_CV_RES 100000.0
R121 Net__R121_Pad1_ 0 47000.0
R200 _FILT_R_OUT Net__U34A___ 100000.0
R201 _MASTER_FILTER_LPR Net__U34A___ 100000.0
R202 _MASTER_FILTER_RESFBR Net__U34A___ 100000.0
R203 Net__U34A___ _MASTER_FILTER_HPR 100000.0
R204 _MASTER_FILTER_HPR Net__U34B___ 100000.0
R205 _MASTER_FILTER_LPR Net__U34B___ 100000.0
R206 Net__U34B___ _MASTER_FILTER_NOTCHR 100000.0
R210 _MASTER_FILTER_HPR Net__U35C___ 22000.0
R211 _MASTER_FILTER_HPR 0 220.0
R212 Net__R212_Pad1_ _MF_CV_CUTOFF 100000.0
R213 _MASTER_FILTER_BPR N5V 10000.0
R214 _MASTER_FILTER_BPR Net__U35A___ 22000.0
R215 _MASTER_FILTER_BPR 0 220.0
R216 Net__R216_Pad1_ _MF_CV_CUTOFF 100000.0
R217 _MASTER_FILTER_LPR N5V 10000.0
R218 _MASTER_FILTER_BPR Net__U36C___ 22000.0
R219 _MASTER_FILTER_BPR 0 220.0
R220 Net__R220_Pad1_ _MF_CV_RES 100000.0
R221 Net__R221_Pad1_ 0 47000.0
XU30 _MASTER_FILTER_HPL Net__U30A___ 0 _MASTER_FILTER_NOTCHL Net__U30B___ 0 P5V N5V OPA1678
XU31A Net__R112_Pad1_ Net__U31C___ 0 Net__C110_Pad1_ Net__C110_Pad1_ _MASTER_FILTER_BPL P5V N5V LM13700_HALF
XU31B Net__R116_Pad1_ Net__U31A___ 0 Net__C114_Pad1_ Net__C114_Pad1_ _MASTER_FILTER_LPL P5V N5V LM13700_HALF
XU32A Net__R120_Pad1_ Net__U32C___ 0 Net__R121_Pad1_ Net__R121_Pad1_ _MASTER_FILTER_RESFBL P5V N5V LM13700_HALF
XU32B nc_U32_16 nc_U32_14 nc_U32_13 nc_U32_12 nc_U32_10 nc_U32_9 P5V N5V LM13700_HALF
XU34 _MASTER_FILTER_HPR Net__U34A___ 0 _MASTER_FILTER_NOTCHR Net__U34B___ 0 P5V N5V OPA1678
XU35A Net__R212_Pad1_ Net__U35C___ 0 Net__C210_Pad1_ Net__C210_Pad1_ _MASTER_FILTER_BPR P5V N5V LM13700_HALF
XU35B Net__R216_Pad1_ Net__U35A___ 0 Net__C214_Pad1_ Net__C214_Pad1_ _MASTER_FILTER_LPR P5V N5V LM13700_HALF
XU36A Net__R220_Pad1_ Net__U36C___ 0 Net__R221_Pad1_ Net__R221_Pad1_ _MASTER_FILTER_RESFBR P5V N5V LM13700_HALF
XU36B nc_U36_16 nc_U36_14 nc_U36_13 nc_U36_12 nc_U36_10 nc_U36_9 P5V N5V LM13700_HALF
R80 _OUTPUT_BUF_BUF_L _LINE_L 100.0
R81 _OUTPUT_BUF_BUF_L _HP_L 22.0
R82 _OUTPUT_BUF_BUF_R _LINE_R 100.0
R83 _OUTPUT_BUF_BUF_R _HP_R 22.0
XU80 Net__Q1_B_ _OUTPUT_BUF_BUF_L _VOL_L Net__Q3_B_ _OUTPUT_BUF_BUF_R _VOL_R P5V N5V OPA1678
C700 P5V 0 100n
C701 N5V 0 100n
C702 P5V 0 100n
C703 N5V 0 100n
C704 P5V 0 100n
C705 N5V 0 100n
C706 P5V 0 100n
C707 N5V 0 100n
R700 _FILT_L_FILT Net__U42A___ 4700.0
R701 Net__U42A___ _FX_CHAIN_DRV_L 47000.0
R710 _FILT_R_FILT Net__U42B___ 4700.0
R711 Net__U42B___ _FX_CHAIN_DRV_R 47000.0
R720 _FX_CHAIN_DRV_L Net__U40C___ 22000.0
R721 _FX_CHAIN_DRV_L 0 220.0
R722 Net__R722_Pad1_ _CV_FX1 100000.0
R723 Net__R723_Pad1_ 0 47000.0
R724 _FX_CHAIN_TREM_L N5V 10000.0
R730 _FX_CHAIN_DRV_R Net__U40A___ 22000.0
R731 _FX_CHAIN_DRV_R 0 220.0
R732 Net__R732_Pad1_ _CV_FX1 100000.0
R733 Net__R733_Pad1_ 0 47000.0
R734 _FX_CHAIN_TREM_R N5V 10000.0
XU40A Net__R722_Pad1_ Net__U40C___ 0 Net__R723_Pad1_ Net__R723_Pad1_ _FX_CHAIN_TREM_L P5V N5V LM13700_HALF
XU40B Net__R732_Pad1_ Net__U40A___ 0 Net__R733_Pad1_ Net__R733_Pad1_ _FX_CHAIN_TREM_R P5V N5V LM13700_HALF
XU42 _FX_CHAIN_DRV_L Net__U42A___ 0 _FX_CHAIN_DRV_R Net__U42B___ 0 P5V N5V OPA1678
.control
ac dec 24 20 20000
wrdata /home/akiel/trunk/pub/signalmesh_CAD/sim/spice/_bode_5.txt db(v(_VOL_L))
.endc
.end

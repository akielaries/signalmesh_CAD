chorus comb (delay=10m)
V1 in 0 dc 0 ac 1
Rs in ina 50
T1 ina 0 outa 0 Z0=600 TD=10m
Rt outa 0 600
Bcomb comb 0 V = 0.5*V(ina) + 0.5*V(outa)
.control
ac dec 60 20 4000
wrdata /home/akiel/trunk/pub/signalmesh_CAD/sim/spice/_ch.txt db(v(comb))
.endc
.end
